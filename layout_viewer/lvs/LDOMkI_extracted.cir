* Extracted by KLayout with GF180MCU LVS runset on : 02/11/2026 20:27

.SUBCKT LDOMkI BandGap Input Output TBias VDD VSS
M$1 VDD \$3 Output VDD pfet_06v0 L=10U W=80U AS=61.6P AD=61.6P PS=161.54U
+ PD=161.54U
M$2 VDD \$I1 \$I1 VDD pfet_06v0 L=4U W=10U AS=7.7P AD=2.6P PS=21.54U PD=10.52U
M$3 \$3 \$I1 VDD VDD pfet_06v0 L=4U W=10U AS=2.6P AD=7.7P PS=10.52U PD=21.54U
M$4 \$I2 Input \$I1 VSS nfet_06v0 L=4U W=10U AS=7.3P AD=2.6P PS=21.46U PD=10.52U
M$5 \$3 BandGap \$I2 VSS nfet_06v0 L=4U W=10U AS=2.6P AD=7.3P PS=10.52U
+ PD=21.46U
M$6 \$I2 TBias VSS VSS nfet_06v0 L=4U W=10U AS=7.3P AD=7.3P PS=21.46U PD=21.46U
.ENDS LDOMkI
