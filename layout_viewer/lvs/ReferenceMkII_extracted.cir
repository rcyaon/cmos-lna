* Extracted by KLayout with GF180MCU LVS runset on : 02/11/2026 20:27

.SUBCKT ReferenceMkII BandGap Out TBias VDD VSS
R$1 \$9 VSS VSS 24000 ppolyf_u_1k L=24U W=1U
R$2 Out \$9 VSS 10000 ppolyf_u_1k L=10U W=1U
C$3 \$9 Out 4.84e-13 cap_mim_2f0fF A=242P P=66U
M$4 VDD \$7 \$7 VDD pfet_06v0 L=4U W=10U AS=7.7P AD=2.6P PS=21.54U PD=10.52U
M$5 \$8 \$7 VDD VDD pfet_06v0 L=4U W=10U AS=2.6P AD=7.7P PS=10.52U PD=21.54U
M$6 \$6 \$9 \$7 VSS nfet_06v0 L=4U W=10U AS=7.3P AD=2.6P PS=21.46U PD=10.52U
M$7 \$8 BandGap \$6 VSS nfet_06v0 L=4U W=10U AS=2.6P AD=7.3P PS=10.52U PD=21.46U
M$8 VSS TBias TBias VSS nfet_06v0 L=4U W=10U AS=7.3P AD=2.6P PS=21.46U PD=10.52U
M$9 \$6 TBias VSS VSS nfet_06v0 L=4U W=10U AS=2.6P AD=7.3P PS=10.52U PD=21.46U
M$10 Out \$8 VDD VDD pfet_06v0 L=10U W=80U AS=31P AD=31P PS=103.1U PD=103.1U
.ENDS ReferenceMkII
